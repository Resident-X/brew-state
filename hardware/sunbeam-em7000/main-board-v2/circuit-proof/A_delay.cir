Interlock: delay from POL_OUT through R207, U201 and U203 to POL_BUF, both edges; 20 pF added on POL_IN for the pin and track
.include A_interlock.cir
.include A_models.inc
Vsup +5V GND 5.25
Vpol POL_OUT GND PWL(0 0 10u 0 10.01u 3.3 40u 3.3 40.01u 0 80u 0)
Cin POL_IN GND 20p
* relay coil, a deck-added load (K201 is excluded from simulation): 62 ohm -10 % = 55.8 ohm
Rcoil +5V POL_COIL_LO 55.8
.options reltol=1e-5 abstol=1e-15 gmin=1e-15
.tran 0.5n 80u
.control
alter R203 = 5.6896Meg
alter R204 = 5.6896Meg
alter C203 = 4.9645n
alter C205 = 4.9645n
alter C202 = 105.6n
alter C204 = 105.6n
run
meas tran tdelay_rise TRIG v(POL_OUT) VAL=1.65 RISE=1 TARG v(POL_BUF) VAL=2.6 RISE=1
meas tran tdelay_fall TRIG v(POL_OUT) VAL=1.65 FALL=1 TARG v(POL_BUF) VAL=2.6 FALL=1
.endc
.end
