Interlock fault: both zeners shorted, the diodes alone clamp (BAS116 limit fit); coil decay per henry
.include A_interlock.cir
.include A_models.inc
Vsup +5V GND 5.25
* the gates are forced: 5.25 V until 1 ms, then 0 V (gate decay is step 1; the FET turn-off allowance is added in the row)
Vga POL_GATE_A GND PWL(0 5.25 1m 5.25 1.001m 0)
Vgb POL_GATE_B GND PWL(0 5.25 1m 5.25 1.001m 0)
* relay coil, deck-added: 62 ohm -10 % = 55.8 ohm in series with L = 1 H (the inductance is open in the records; the time scales with L)
* fault: both zeners shorted, a deck-added 10 mohm across each
Rzs1 POL_CLAMP_1 POL_COIL_LO 0.01
Rzs2 POL_CLAMP_2 POL_COIL_LO 0.01
Vsense +5V KA 0
Rcoil KA KB 55.8
Lcoil KB POL_COIL_LO 1 IC=0.094086
* the stack's midpoint is floating while both FETs are off; its leakage is modelled as 100 Mohm (a convergence aid, deck-added)
Rmid POL_MID GND 100Meg
.options reltol=1e-4 abstol=1e-10 gmin=1e-12 itl4=200 method=gear
.tran 5u 29m 0 20u
.control
run
meas tran i0 FIND i(Vsense) AT=0.9m
meas tran tcoil_per_H TRIG AT=1.001m TARG i(Vsense) VAL=7.3m FALL=1
.endc
.end
