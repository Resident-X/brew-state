Zero-crossing detector: R630 R631 U602 R632 C630, every end of the stated spreads, output edges against the controller's thresholds
* Generated by E_zc_delay_gen.py; inputs and sources are listed there.  Refs and values are the sheet "Zero-crossing detector"'s.
* U602 is modelled: two antiparallel diodes (the LED) and a collector current source CTR x |IF| with a saturation knee and a response lag.
* Vsns is a 0 V current probe; Vctr holds CTR; Vsup is the +3V3 rail; Vgnd ties NEUTRAL to the simulator's ground (GND is ground by name);
* Vamp sets the supply's peak and Bline is the supply: V = Vamp x sin(2 pi 50 t), zero crossings at t = 0, 10 ms, 20 ms ...
R630 LINE ZC_N1 60.4k
R631 ZC_N1 ZC_LED_A 60.4k
Vsns ZC_LED_A ZC_LEDM 0
D1 ZC_LEDM NEUTRAL DLED
D2 NEUTRAL ZC_LEDM DLED
.model DLED D(IS=3.5e-14 N=2)
Bif ZC_IF 0 V=abs(i(Vsns))*1k
Rlag ZC_IF ZC_IFL 1k
Clag ZC_IFL 0 8.2n
Gq ZC_IN GND VALUE={v(CTRN)*v(ZC_IFL)/1k*tanh(v(ZC_IN)/0.2)}
R632 ZC_IN +3V3 22k
C630 ZC_IN GND 1n
Vctr CTRN 0 0.2
Vsup +3V3 0 3.3
Vgnd NEUTRAL 0 0
Vamp AMPN 0 357.8
Bline LINE NEUTRAL V=v(AMPN)*sin(2*3.14159265*50*time)
.tran 5u 60m
.control
alter Vamp = 305.470
alter R630 = 59530.0
alter R631 = 59530.0
alter Vctr = 0.2
altermod D1 is = 3.5e-14
altermod D2 is = 3.5e-14
alter Vsup = 3.0
run
meas tran tf_1 WHEN v(ZC_IN)=0.900 FALL=3
meas tran tr_1 WHEN v(ZC_IN)=2.100 RISE=3
alter Vamp = 305.470
alter R630 = 59530.0
alter R631 = 59530.0
alter Vctr = 0.2
altermod D1 is = 3.5e-14
altermod D2 is = 3.5e-14
alter Vsup = 3.6
run
meas tran tf_2 WHEN v(ZC_IN)=1.080 FALL=3
meas tran tr_2 WHEN v(ZC_IN)=2.520 RISE=3
alter Vamp = 305.470
alter R630 = 59530.0
alter R631 = 59530.0
alter Vctr = 0.2
altermod D1 is = 1.6e-12
altermod D2 is = 1.6e-12
alter Vsup = 3.0
run
meas tran tf_3 WHEN v(ZC_IN)=0.900 FALL=3
meas tran tr_3 WHEN v(ZC_IN)=2.100 RISE=3
alter Vamp = 305.470
alter R630 = 59530.0
alter R631 = 59530.0
alter Vctr = 0.2
altermod D1 is = 1.6e-12
altermod D2 is = 1.6e-12
alter Vsup = 3.6
run
meas tran tf_4 WHEN v(ZC_IN)=1.080 FALL=3
meas tran tr_4 WHEN v(ZC_IN)=2.520 RISE=3
alter Vamp = 305.470
alter R630 = 59530.0
alter R631 = 59530.0
alter Vctr = 3.0
altermod D1 is = 3.5e-14
altermod D2 is = 3.5e-14
alter Vsup = 3.0
run
meas tran tf_5 WHEN v(ZC_IN)=0.900 FALL=3
meas tran tr_5 WHEN v(ZC_IN)=2.100 RISE=3
alter Vamp = 305.470
alter R630 = 59530.0
alter R631 = 59530.0
alter Vctr = 3.0
altermod D1 is = 3.5e-14
altermod D2 is = 3.5e-14
alter Vsup = 3.6
run
meas tran tf_6 WHEN v(ZC_IN)=1.080 FALL=3
meas tran tr_6 WHEN v(ZC_IN)=2.520 RISE=3
alter Vamp = 305.470
alter R630 = 59530.0
alter R631 = 59530.0
alter Vctr = 3.0
altermod D1 is = 1.6e-12
altermod D2 is = 1.6e-12
alter Vsup = 3.0
run
meas tran tf_7 WHEN v(ZC_IN)=0.900 FALL=3
meas tran tr_7 WHEN v(ZC_IN)=2.100 RISE=3
alter Vamp = 305.470
alter R630 = 59530.0
alter R631 = 59530.0
alter Vctr = 3.0
altermod D1 is = 1.6e-12
altermod D2 is = 1.6e-12
alter Vsup = 3.6
run
meas tran tf_8 WHEN v(ZC_IN)=1.080 FALL=3
meas tran tr_8 WHEN v(ZC_IN)=2.520 RISE=3
alter Vamp = 305.470
alter R630 = 61280.0
alter R631 = 61280.0
alter Vctr = 0.2
altermod D1 is = 3.5e-14
altermod D2 is = 3.5e-14
alter Vsup = 3.0
run
meas tran tf_9 WHEN v(ZC_IN)=0.900 FALL=3
meas tran tr_9 WHEN v(ZC_IN)=2.100 RISE=3
alter Vamp = 305.470
alter R630 = 61280.0
alter R631 = 61280.0
alter Vctr = 0.2
altermod D1 is = 3.5e-14
altermod D2 is = 3.5e-14
alter Vsup = 3.6
run
meas tran tf_10 WHEN v(ZC_IN)=1.080 FALL=3
meas tran tr_10 WHEN v(ZC_IN)=2.520 RISE=3
alter Vamp = 305.470
alter R630 = 61280.0
alter R631 = 61280.0
alter Vctr = 0.2
altermod D1 is = 1.6e-12
altermod D2 is = 1.6e-12
alter Vsup = 3.0
run
meas tran tf_11 WHEN v(ZC_IN)=0.900 FALL=3
meas tran tr_11 WHEN v(ZC_IN)=2.100 RISE=3
alter Vamp = 305.470
alter R630 = 61280.0
alter R631 = 61280.0
alter Vctr = 0.2
altermod D1 is = 1.6e-12
altermod D2 is = 1.6e-12
alter Vsup = 3.6
run
meas tran tf_12 WHEN v(ZC_IN)=1.080 FALL=3
meas tran tr_12 WHEN v(ZC_IN)=2.520 RISE=3
alter Vamp = 305.470
alter R630 = 61280.0
alter R631 = 61280.0
alter Vctr = 3.0
altermod D1 is = 3.5e-14
altermod D2 is = 3.5e-14
alter Vsup = 3.0
run
meas tran tf_13 WHEN v(ZC_IN)=0.900 FALL=3
meas tran tr_13 WHEN v(ZC_IN)=2.100 RISE=3
alter Vamp = 305.470
alter R630 = 61280.0
alter R631 = 61280.0
alter Vctr = 3.0
altermod D1 is = 3.5e-14
altermod D2 is = 3.5e-14
alter Vsup = 3.6
run
meas tran tf_14 WHEN v(ZC_IN)=1.080 FALL=3
meas tran tr_14 WHEN v(ZC_IN)=2.520 RISE=3
alter Vamp = 305.470
alter R630 = 61280.0
alter R631 = 61280.0
alter Vctr = 3.0
altermod D1 is = 1.6e-12
altermod D2 is = 1.6e-12
alter Vsup = 3.0
run
meas tran tf_15 WHEN v(ZC_IN)=0.900 FALL=3
meas tran tr_15 WHEN v(ZC_IN)=2.100 RISE=3
alter Vamp = 305.470
alter R630 = 61280.0
alter R631 = 61280.0
alter Vctr = 3.0
altermod D1 is = 1.6e-12
altermod D2 is = 1.6e-12
alter Vsup = 3.6
run
meas tran tf_16 WHEN v(ZC_IN)=1.080 FALL=3
meas tran tr_16 WHEN v(ZC_IN)=2.520 RISE=3
alter Vamp = 357.796
alter R630 = 59530.0
alter R631 = 59530.0
alter Vctr = 0.2
altermod D1 is = 3.5e-14
altermod D2 is = 3.5e-14
alter Vsup = 3.0
run
meas tran tf_17 WHEN v(ZC_IN)=0.900 FALL=3
meas tran tr_17 WHEN v(ZC_IN)=2.100 RISE=3
alter Vamp = 357.796
alter R630 = 59530.0
alter R631 = 59530.0
alter Vctr = 0.2
altermod D1 is = 3.5e-14
altermod D2 is = 3.5e-14
alter Vsup = 3.6
run
meas tran tf_18 WHEN v(ZC_IN)=1.080 FALL=3
meas tran tr_18 WHEN v(ZC_IN)=2.520 RISE=3
alter Vamp = 357.796
alter R630 = 59530.0
alter R631 = 59530.0
alter Vctr = 0.2
altermod D1 is = 1.6e-12
altermod D2 is = 1.6e-12
alter Vsup = 3.0
run
meas tran tf_19 WHEN v(ZC_IN)=0.900 FALL=3
meas tran tr_19 WHEN v(ZC_IN)=2.100 RISE=3
alter Vamp = 357.796
alter R630 = 59530.0
alter R631 = 59530.0
alter Vctr = 0.2
altermod D1 is = 1.6e-12
altermod D2 is = 1.6e-12
alter Vsup = 3.6
run
meas tran tf_20 WHEN v(ZC_IN)=1.080 FALL=3
meas tran tr_20 WHEN v(ZC_IN)=2.520 RISE=3
alter Vamp = 357.796
alter R630 = 59530.0
alter R631 = 59530.0
alter Vctr = 3.0
altermod D1 is = 3.5e-14
altermod D2 is = 3.5e-14
alter Vsup = 3.0
run
meas tran tf_21 WHEN v(ZC_IN)=0.900 FALL=3
meas tran tr_21 WHEN v(ZC_IN)=2.100 RISE=3
alter Vamp = 357.796
alter R630 = 59530.0
alter R631 = 59530.0
alter Vctr = 3.0
altermod D1 is = 3.5e-14
altermod D2 is = 3.5e-14
alter Vsup = 3.6
run
meas tran tf_22 WHEN v(ZC_IN)=1.080 FALL=3
meas tran tr_22 WHEN v(ZC_IN)=2.520 RISE=3
alter Vamp = 357.796
alter R630 = 59530.0
alter R631 = 59530.0
alter Vctr = 3.0
altermod D1 is = 1.6e-12
altermod D2 is = 1.6e-12
alter Vsup = 3.0
run
meas tran tf_23 WHEN v(ZC_IN)=0.900 FALL=3
meas tran tr_23 WHEN v(ZC_IN)=2.100 RISE=3
alter Vamp = 357.796
alter R630 = 59530.0
alter R631 = 59530.0
alter Vctr = 3.0
altermod D1 is = 1.6e-12
altermod D2 is = 1.6e-12
alter Vsup = 3.6
run
meas tran tf_24 WHEN v(ZC_IN)=1.080 FALL=3
meas tran tr_24 WHEN v(ZC_IN)=2.520 RISE=3
alter Vamp = 357.796
alter R630 = 61280.0
alter R631 = 61280.0
alter Vctr = 0.2
altermod D1 is = 3.5e-14
altermod D2 is = 3.5e-14
alter Vsup = 3.0
run
meas tran tf_25 WHEN v(ZC_IN)=0.900 FALL=3
meas tran tr_25 WHEN v(ZC_IN)=2.100 RISE=3
alter Vamp = 357.796
alter R630 = 61280.0
alter R631 = 61280.0
alter Vctr = 0.2
altermod D1 is = 3.5e-14
altermod D2 is = 3.5e-14
alter Vsup = 3.6
run
meas tran tf_26 WHEN v(ZC_IN)=1.080 FALL=3
meas tran tr_26 WHEN v(ZC_IN)=2.520 RISE=3
alter Vamp = 357.796
alter R630 = 61280.0
alter R631 = 61280.0
alter Vctr = 0.2
altermod D1 is = 1.6e-12
altermod D2 is = 1.6e-12
alter Vsup = 3.0
run
meas tran tf_27 WHEN v(ZC_IN)=0.900 FALL=3
meas tran tr_27 WHEN v(ZC_IN)=2.100 RISE=3
alter Vamp = 357.796
alter R630 = 61280.0
alter R631 = 61280.0
alter Vctr = 0.2
altermod D1 is = 1.6e-12
altermod D2 is = 1.6e-12
alter Vsup = 3.6
run
meas tran tf_28 WHEN v(ZC_IN)=1.080 FALL=3
meas tran tr_28 WHEN v(ZC_IN)=2.520 RISE=3
alter Vamp = 357.796
alter R630 = 61280.0
alter R631 = 61280.0
alter Vctr = 3.0
altermod D1 is = 3.5e-14
altermod D2 is = 3.5e-14
alter Vsup = 3.0
run
meas tran tf_29 WHEN v(ZC_IN)=0.900 FALL=3
meas tran tr_29 WHEN v(ZC_IN)=2.100 RISE=3
alter Vamp = 357.796
alter R630 = 61280.0
alter R631 = 61280.0
alter Vctr = 3.0
altermod D1 is = 3.5e-14
altermod D2 is = 3.5e-14
alter Vsup = 3.6
run
meas tran tf_30 WHEN v(ZC_IN)=1.080 FALL=3
meas tran tr_30 WHEN v(ZC_IN)=2.520 RISE=3
alter Vamp = 357.796
alter R630 = 61280.0
alter R631 = 61280.0
alter Vctr = 3.0
altermod D1 is = 1.6e-12
altermod D2 is = 1.6e-12
alter Vsup = 3.0
run
meas tran tf_31 WHEN v(ZC_IN)=0.900 FALL=3
meas tran tr_31 WHEN v(ZC_IN)=2.100 RISE=3
alter Vamp = 357.796
alter R630 = 61280.0
alter R631 = 61280.0
alter Vctr = 3.0
altermod D1 is = 1.6e-12
altermod D2 is = 1.6e-12
alter Vsup = 3.6
run
meas tran tf_32 WHEN v(ZC_IN)=1.080 FALL=3
meas tran tr_32 WHEN v(ZC_IN)=2.520 RISE=3
.endc
.end
