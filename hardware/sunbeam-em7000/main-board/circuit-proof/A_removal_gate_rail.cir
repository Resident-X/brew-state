Interlock removal, step 1, start at the rail top (no diode drop): gate decay to the lowest FET threshold, slowest corner
.include A_interlock.cir
.include A_models.inc
Vsup +5V GND 5.25
Vpol POL_OUT GND 0
* FET input capacitance at its datasheet maximum, 50 pF (NX3008NBK Table 7), one per gate
Cg201 POL_GATE_A GND 50p
Cg202 POL_GATE_B GND 50p
* relay coil, a deck-added load (K201 is excluded from simulation): 62 ohm -10 % = 55.8 ohm
Rcoil +5V POL_COIL_LO 55.8
.ic v(POL_GATE_A)=5.25 v(POL_GATE_B)=5.25 v(POL_NODE_A)=0 v(POL_NODE_B)=0 v(POL_BUF)=0 v(POL_MID)=0 v(POL_COIL_LO)=0
.options reltol=1e-5 abstol=1e-15 gmin=1e-15
.tran 2u 300m 0 5u uic
.control
alter R203 = 5.6896Meg
alter R204 = 5.6896Meg
alter C203 = 4.9645n
alter C205 = 4.9645n
alter C202 = 105.6n
alter C204 = 105.6n
run
meas tran tR06 WHEN v(POL_GATE_A)=0.6 FALL=1
meas tran tR05 WHEN v(POL_GATE_A)=0.5 FALL=1
.endc
.end
